// Design: fram_cells3/all_cells
simulator lang=spectre
global 0
include "models.scs"

// fram_cells3/memory_cell/schematic
.subckt memory_cell bl gnd pl wn
M0 (net6 wn bl gnd) nsvt25 w=0.4 l=0.28 nfing=1 mult=1 srcefirst=1 mismatch=1
    I0 (pl net6) conder Ec=1.9 dT=1e-09 l=5e-07 w=5e-07 p00=0.25
.ends memory_cell

// fram_cells3/off_driver/schematic
.subckt off_driver BL IN VDD
M1 (BL IN VDD VDD) psvt25 w=0.4 l=0.28 nfing=1 mult=1 srcefirst=1 mismatch=1
.ends off_driver

// fram_cells3/sense_amp/schematic
.subckt sense_amp gnd in nb nt ref seb vdd
M3 (nb seb gnd gnd) nsvt25 w=0.4 l=0.28 nfing=1 mult=1 srcefirst=1 mismatch=1
M2 (gnd seb nt gnd) nsvt25 w=0.4 l=0.28 nfing=1 mult=1 srcefirst=1 mismatch=1
M1 (nt nb gnd gnd) nsvt25 w=0.4 l=0.28 nfing=1 mult=1 srcefirst=1 mismatch=1
M0 (gnd nt nb gnd) nsvt25 w=0.4 l=0.28 nfing=1 mult=1 srcefirst=1 mismatch=1
M8 (net25 seb vdd vdd) psvt25 w=0.4 l=0.28 nfing=1 mult=1 srcefirst=1 mismatch=1
M7 (net25 ref net33 vdd) psvt25 w=0.4 l=0.28 nfing=1 mult=1 srcefirst=1 mismatch=1
M6 (net29 in net25 vdd) psvt25 w=0.4 l=0.28 nfing=1 mult=1 srcefirst=1 mismatch=1
M5 (nt nb net33 vdd) psvt25 w=0.4 l=0.28 nfing=1 mult=1 srcefirst=1 mismatch=1
M4 (net29 nt nb vdd) psvt25 w=0.4 l=0.28 nfing=1 mult=1 srcefirst=1 mismatch=1
.ends sense_amp

// fram_cells5/1u_invertor/schematic
.subckt fram_cells5_1u_invertor_schematic gnd in out vdd
M0 (out in gnd gnd) nsvt25 w=1.0 l=0.28 nfing=1 mult=1 srcefirst=1 mismatch=1
M1 (out in vdd vdd) psvt25 w=1.0 l=0.28 nfing=1 mult=1 srcefirst=1 mismatch=1
.ends fram_cells5_1u_invertor_schematic

// fram_cells3/all_cells/schematic
I0 (BL 0 PL net2) memory_cell
I1 (BL net7 VDD) off_driver
I2 (0 BL net11 net10 net13 net14 VDD) sense_amp
I3 (0 net010 PL VDD) fram_cells5_1u_invertor_schematic
simulatorOptions options temp=27
saveOptions options subcktprobelvl=2
ahdl_include "/home/solovyanov_m/work_shell/fram_cells/conder/veriloga/veriloga.va"
